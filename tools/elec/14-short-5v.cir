* 14 5V jumpered to GND (0.05 ohm): only the PC USB port limit is left
*tb: LIMIT v5 5 0.5 0.5 20
*tb: LDO v5 v33 3.3 0.01 0.525 1.2 0.0001
*tb: LOAD v33 0.035 1
B1 0 v5 I=max(0, min((5-v(v5))/0.5, 0.5+(5-0.25-v(v5))/20))
B2 0 v33 I=max(0, min(min((3.3-v(v33))/0.01, (v(v5)-v(v33))/0.525), 1.2))
B3 v5 0 I=max(0, min(min((3.3-v(v33))/0.01, (v(v5)-v(v33))/0.525), 1.2))+0.0001
B4 v33 0 I=max(0, min(0.035, v(v33)*0.035/1))
R1 v5 0 0.05
.op
.end
