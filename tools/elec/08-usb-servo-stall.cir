* 08 USB 限流 + 舵机堵转（电机 6.86 Ω，满电压）：限流开关进恒流区，5V 轨掉到 3.6 V 左右
*tb: LIMIT v5 5 0.5 0.5 20
*tb: LDO v5 v33 3.3 0.01 0.525 1.2 0
*tb: LOAD v33 0.055 1
R1 v5 sv 0.15
*tb: MOTOR sv 6 0 6.857142857
B1 0 v5 I=max(0, min((5-v(v5))/0.5, 0.5+(5-0.25-v(v5))/20))
B2 0 v33 I=max(0, min(min((3.3-v(v33))/0.01, (v(v5)-v(v33))/0.525), 1.2))
B3 v5 0 I=max(0, min(min((3.3-v(v33))/0.01, (v(v5)-v(v33))/0.525), 1.2))
B4 v33 0 I=max(0, min(0.055, v(v33)*0.055/1))
B5 sv 0 I=max(0, min((v(sv)-0)/6.857142857, (6-0)/6.857142857))
.nodeset v(v5)=5 v(v33)=3.3 v(vin)=3.4 v(vout)=3.3 v(sv)=5
.op
.end
