* 12 W3 LED without resistor: GPIO high (33 ohm) -> red LED (1.8 V knee + 10 ohm PWL) -> GND
V1 vg 0 DC 3.3
R1 vg pin 33
R2 pin an 1m
*tb: DIODE an 0 1.8 10
B1 an 0 I=max(0, (v(an)-1.8)/10)
.op
.end
