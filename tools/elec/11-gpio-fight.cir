* 11 W1 output fight (worst pair): pot wiper at the GND end (1 ohm contact) vs GPIO driving high (33 ohm default drive)
V1 vd 0 DC 0
R1 vd pin 1
R2 pin vg 33
V2 vg 0 DC 3.3
.op
.end
