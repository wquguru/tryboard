* 05 RC charge: 3.3 V through 1 k into 10 uF (tau = 10 ms)
V1 in 0 DC 3.3
R1 in out 1k
C1 out 0 10u
.tran 10u 20m
.end
