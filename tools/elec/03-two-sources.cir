* 03 两个带内阻的源并联给同一负载（USB 5 V 与 4.8 V 电池）
V1 s1 0 DC 5
R1 s1 n 0.5
V2 s2 0 DC 4.8
R2 s2 n 0.3
RL n 0 10
.op
.end
