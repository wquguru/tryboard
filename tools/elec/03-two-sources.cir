* 03 Two sources with internal resistance in parallel on one load (USB 5 V and a 4.8 V battery)
V1 s1 0 DC 5
R1 s1 n 0.5
V2 s2 0 DC 4.8
R2 s2 n 0.3
RL n 0 10
.op
.end
