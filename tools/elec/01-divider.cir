* 01 Divider: 5 V, 1 k / 2.2 k
V1 in 0 DC 5
R1 in out 1k
R2 out 0 2.2k
.op
.end
