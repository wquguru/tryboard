* 10 欠压瞬态：USB 限流 + 10 µF / 22 µF 去耦 + 舵机反接制动（反电动势 −3.77 V），从电容未充电起算
*tb: LIMIT v5 5 0.5 0.5 20
*tb: LDO v5 v33 3.3 0.01 0.525 1.2 0
*tb: LOAD v33 0.055 1
R1 v5 sv 0.15
*tb: MOTOR sv 6 -3.77 6.857142857
C1 v5 0 10u
C2 v33 0 22u
B1 0 v5 I=max(0, min((5-v(v5))/0.5, 0.5+(5-0.25-v(v5))/20))
B2 0 v33 I=max(0, min(min((3.3-v(v33))/0.01, (v(v5)-v(v33))/0.525), 1.2))
B3 v5 0 I=max(0, min(min((3.3-v(v33))/0.01, (v(v5)-v(v33))/0.525), 1.2))
B4 v33 0 I=max(0, min(0.055, v(v33)*0.055/1))
B5 sv 0 I=max(0, min((v(sv)+3.77)/6.857142857, (6+3.77)/6.857142857))
.tran 1u 2m
.end
