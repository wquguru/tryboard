* 04 Current source into a T network (GPIO pushing 10 mA through a series resistor into an LED-like resistance)
I1 0 a DC 10m
R1 a b 220
R2 b 0 150
R3 a 0 1k
.op
.end
